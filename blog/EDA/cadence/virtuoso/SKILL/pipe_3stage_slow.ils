(let ()
  (defun _calcBestK1K2AndSxxR_Spec (V1 V2 V3 FFT_start N fs measType)
    (let ((bestK1 1.0)
          (bestK2 1.0)
          (maxVal nil)
          currentK1
          currentK2
          val
          testWave
          (time_stop (plus FFT_start (quotient (float N) fs)))
          (fund_freq (quotient (float fs) N))
          (max_freq  (times 0.5 fs))
          (useMeasType (if (equal measType "sndr") "sinad" measType))
          )

      (for i 0 60
           (setq currentK1 (plus 1.0 (times i 0.01))) ;; k1 1.00 to 1.60
           (for j 0 60
                (setq currentK2 (plus 1.0 (times j 0.01))) ;; k2 1.00 to 1.60

                ;; Formula: V1 + k1 * (V2 + k2 * V3)
                (setq testWave (plus V1 (times currentK1 (plus V2 (times currentK2 V3)))))

                (setq val (spectrumMeasurement
                           testWave
                           t
                           FFT_start
                           time_stop
                           N
                           fund_freq
                           max_freq
                           0
                           "Rectangular"
                           0.0
                           0
                           10
                           useMeasType
                           ))

                (when (or (null maxVal) (greaterp val maxVal))
                  (setq maxVal val)
                  (setq bestK1 currentK1)
                  (setq bestK2 currentK2))))
      (list bestK1 bestK2 maxVal)))

  (defglobalfun getBestK1 (V1 V2 V3 FFT_start N fs measType)
    (cond
      ((drIsWaveform V1)
       (nth 0 (_calcBestK1K2AndSxxR_Spec V1 V2 V3 FFT_start N fs measType)))
      ((famIsFamily V1)
       (famMap 'getBestK1 V1 V2 V3 FFT_start N fs measType))
      (t nil)))

  (defglobalfun getBestK2 (V1 V2 V3 FFT_start N fs measType)
    (cond
      ((drIsWaveform V1)
       (nth 1 (_calcBestK1K2AndSxxR_Spec V1 V2 V3 FFT_start N fs measType)))
      ((famIsFamily V1)
       (famMap 'getBestK2 V1 V2 V3 FFT_start N fs measType))
      (t nil)))

  (defglobalfun getMaxSxxR_3stage (V1 V2 V3 FFT_start N fs measType)
    (cond
      ((drIsWaveform V1)
       (nth 2 (_calcBestK1K2AndSxxR_Spec V1 V2 V3 FFT_start N fs measType)))
      ((famIsFamily V1)
       (famMap 'getMaxSxxR_3stage V1 V2 V3 FFT_start N fs measType))
      (t nil)))
);
